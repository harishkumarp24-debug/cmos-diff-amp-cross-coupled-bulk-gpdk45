// Design: DIFF_AMP/DIFF_AMP@
simulator lang=spectre
global 0
include "/home/install/FOUNDRY/analog/180nm/models/spectre/gpdk.scs" section=stat
include "/home/install/FOUNDRY/analog/45nm/gpdk045/../models/spectre/gpdk045.scs" section=mc

// DIFF_AMP/DIFF_AMP@/schematic
NM10 (net5 net6 net4 0) g45n1svt w=(150n) l=45n nf=1 m=(1)
NM9 (net11 net3 0 0) g45n1svt w=(180n) l=135n nf=1 m=(1)
NM8 (0 net3 net2 0) g45n1svt w=(300n) l=45n nf=1 m=(1)
NM7 (net4 net10 0 0) g45n1svt w=(200n) l=45n nf=1 m=(1)
NM6 (0 net10 net10 0) g45n1svt w=(180n) l=45n nf=1 m=(1)
NM0 (vout1 net8 net2 0) g45n1svt w=(145n) l=45n nf=1 m=(1)
NM1 (net2 net7 vout2 0) g45n1svt w=(145n) l=45n nf=1 m=(1)
PM2 (net9 net1 net5 net6) g45p1svt w=(4.6u) l=45n nf=1 m=(1)
PM0 (vout1 net1 net9 vout2) g45p1svt w=(300n) l=45n nf=1 m=(1)
PM1 (net9 net1 vout2 vout1) g45p1svt w=(300n) l=45n nf=1 m=(1)
V1 (net6 0) vsource dc=300.0m type=dc
V2 (net9 0) vsource dc=1 type=dc
I15 (net9 net11) isource dc=54n type=dc
I16 (net9 net10) isource dc=95n type=dc
V3 (net7 0) vsource dc=500.0m mag=500.0m phase=180 type=pulse val0=510.0m val1=490.0m period=10u rise=1n fall=1n width=5u
V0 (net8 0) vsource dc=500.0m mag=500.0m phase=0 type=pulse val0=490.0m val1=510.0m period=10u rise=1n fall=1n width=5u
simulatorOptions options temp=27
tran tran stop=50u errpreset=moderate
dcOp dc
dc dc dev=V1 param=dc start=0 stop=1
ac ac start=1 stop=100M dec=100
save vout2 vout1 net8 net7
saveOptions options save=all pwr=all
